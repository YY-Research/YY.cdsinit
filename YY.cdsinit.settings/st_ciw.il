;;================================
;; Filename: YY.cdsinit.settings/st_ciw.il
;; Version: 4.0.0
;; Date: Aug. 27, 2026
;; Last Edited By: YY
;;================================
;; YY.cdsinit CIW Settings and Keybindings
;;================================

procedure( YY_ciw_settings()
    ;; CIW keybindings
    hiSetFont("ciw" ?size 16)
    hiSetFont("label" ?name "Open Sans" ?size 16)
    hiSetFont("text" ?name "Open Sans" ?size 16)
)
